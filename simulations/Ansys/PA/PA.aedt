# Ansys Electronics Desktop project, version 2024.2
materials:
  copper: permeability=0.999991 conductivity=58000000
  FR4_epoxy: permittivity=4.4 dielectric_loss_tangent=0.02

design Circuit1 (Circuit)
options: SParamCircuitDef IntegrationMethod=FFT
components:
  C3 = CAP_(C=6.5pF)
  L4 = IND_(L=20nH)
  port Port1 rz=27.07ohm iz=31.19ohm EnableNoise=false noisetemp=16.85cel
  port Port2 rz=50ohm iz=0ohm EnableNoise=false noisetemp=16.85cel
nets:
  0: L4.1
  Port1: C3.0
  Port2: C3.1, L4.0
setups:
  sim_434MHz: LinearFrequencyData(false, 0.1, false, "", false) SweepDefinition{Variable=Freq Data="LIN 100MHz 1GHz 1MHz"}
reports:
  Smith: S(Port2,Port2) on sim_434MHz : sim_434MHz [Freq=all]; markers m1 at 0.434GHz, m2 at 0.434GHz
  S12, S21: dB(S(Port2,Port1)), dB(S(Port1,Port2)) vs Freq on sim_434MHz : sim_434MHz; markers m1 at 0.437GHz, m2 at 0.434GHz
  S11, S22: dB(S(Port1,Port1)), dB(S(Port2,Port2)) vs Freq on sim_434MHz : sim_434MHz; markers m1 at 0.434GHz, m2 at 0.434GHz
