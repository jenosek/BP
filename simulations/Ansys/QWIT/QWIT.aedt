# Ansys Electronics Desktop project, version 2024.2
materials:
  copper: permeability=0.999991 conductivity=58000000
  FR4_epoxy: permittivity=4.4 dielectric_loss_tangent=0.02

design Circuit1 (Circuit)
options: SParamCircuitDef IntegrationMethod=FFT
variables:
  c = 6pF  # tune 3pF..10pF
components:
  C1 = CAP_(C=c)
  C2 = CAP_(C=c)
  L3 = IND_(L=18n)
  port Port1 rz=50ohm iz=0ohm EnableNoise=false noisetemp=16.85cel
  port Port2 rz=50ohm iz=0ohm EnableNoise=false noisetemp=16.85cel
nets:
  0: C1.0, C2.0
  Port1: C1.1, L3.0
  Port2: L3.1, C2.1
setups:
  LinearFrequency: LinearFrequencyData(false, 0.1, false, "", false) SweepDefinition{Variable=Freq Data="LINC 100MHz 1GHz 20000"}
optimetrics:
  ParametricSetup1: Parametric UseFastCalculationUpdateAlgo SaveSolutions Sim._Setups=[LinearFrequency]
    sweep c: LIN 3pF 10pF 0.1pF
reports:
  S11, S22: dB(S(Port1,Port1)), dB(S(Port2,Port2)) vs Freq on LinearFrequency : LinearFrequency; markers m1 at 0.4340967GHz
  Smith: S(Port1,Port1), S(Port2,Port2) on LinearFrequency : LinearFrequency [Freq=all]; markers m1 at 0.43643682GHz
  S12, S21: dB(S(Port2,Port1)), dB(S(Port1,Port2)) vs Freq on LinearFrequency : LinearFrequency; markers m1 at 0.43423423GHz
