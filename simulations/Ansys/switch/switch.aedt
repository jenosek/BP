# Ansys Electronics Desktop project, version 2024.2
materials:
  copper: permeability=0.999991 conductivity=58000000
  FR4_epoxy: permittivity=4.4 dielectric_loss_tangent=0.02

design Circuit1 (Circuit)
options: SParamCircuitDef IntegrationMethod=FFT
variables:
  c = 8.8pF  # tune 6pF..11pF
components:
  R8 = RES_(R=2)
  L9 = IND_(L=0.4n)
  R1 = RES_(R=2)
  L1 = IND_(L=0.4n)
  L2 = IND_(L=88n)
  C93 = CAP_(C=1e-07farad)
  L3 = IND_(L=18n)
  C101 = CAP_(C=c)
  C102 = CAP_(C=c)
  C1 = CAP_(C=1e-07farad)
  C2 = CAP_(C=1e-07farad)
  C3 = CAP_(C=1e-07farad)
  R2 = RES_(R=2)
  L4 = IND_(L=0.4n)
  R3 = RES_(R=2)
  L5 = IND_(L=0.4n)
  L6 = IND_(L=88n)
  C4 = CAP_(C=1e-07farad)
  L7 = IND_(L=18n)
  C5 = CAP_(C=c)
  C6 = CAP_(C=c)
  C7 = CAP_(C=1e-07farad)
  C8 = CAP_(C=1e-07farad)
  C9 = CAP_(C=1e-07farad)
  C151 = CAP_(C=0.3p)
  C10 = CAP_(C=0.3p)
  R155 = RES_(R=300k)
  R4 = RES_(R=300k)
  port R_ANT rz=50ohm iz=0ohm EnableNoise=false noisetemp=16.85cel
  port R_Rx rz=50ohm iz=0ohm EnableNoise=false noisetemp=16.85cel
  port R_TX rz=50ohm iz=0ohm EnableNoise=false noisetemp=16.85cel
  port T_ANT rz=50ohm iz=0ohm EnableNoise=false noisetemp=16.85cel
  port T_RX rz=50ohm iz=0ohm EnableNoise=false noisetemp=16.85cel
  port T_TX rz=50ohm iz=0ohm EnableNoise=false noisetemp=16.85cel
  port VCC rz=50ohm iz=0ohm EnableNoise=false noisetemp=16.85cel
nets:
  0: C93.0, L1.1, C101.0, C102.0, C5.0, C6.0, L5.1, C4.0, C4.1, L6.0, R155.0
  net_1: C7.1, C5.1, R2.0, L7.0, R4.0
  net_10: R2.1, C151.0
  net_11: R8.0, C101.1, L3.0, C1.1
  net_12: L9.1, L2.1, C2.0
  net_13: R8.1, L9.0
  net_14: L1.0, R1.1
  net_15: R1.0, L3.1, C102.1, C3.0
  net_16: L5.0, C10.0
  net_2: C8.0, L4.1, L6.1, R4.1
  net_3: C6.1, R3.0, L7.1, R155.1, C9.0
  net_4: L4.0, C151.1
  net_5: R3.1, C10.1
  R_ANT: C7.0
  R_RX: port R_Rx, C9.1
  R_TX: C8.1
  T_ANT: C1.0
  T_RX: C3.1
  T_TX: C2.1
  VCC: C93.1, L2.0
setups:
  434meg: LinearFrequencyData(false, 0.1, false, "", false) SweepDefinition{Variable=Freq Data=434MHz}
  LinearFrequency: LinearFrequencyData(false, 0.1, false, "", false) SweepDefinition{Variable=Freq Data="434MHz LINC 0.1GHz 1GHz 1000"}
optimetrics:
  ParametricSetup1: Parametric UseFastCalculationUpdateAlgo SaveSolutions Sim._Setups=[434meg, LinearFrequency]
    sweep c: LIN 6pF 10pF 0.1pF
reports:
  T -S11, S22: dB(S(T_ANT,T_ANT)), dB(S(T_TX, T_TX)) vs Freq on LinearFrequency : LinearFrequency; markers m1 at 0.434GHz, m2 at 0.434GHz
  T - isolation: dB(S(T_RX,T_TX)), dB(S(T_TX,T_RX)), dB(S(T_RX,T_ANT)), dB(S(T_ANT,T_RX)) vs Freq on LinearFrequency : LinearFrequency; markers m1 at 0.434GHz, m2 at 0.434GHz
  T - S12, S21: dB(S(T_ANT,  T_TX)), dB(S(T_TX,  T_ANT)) vs Freq on LinearFrequency : LinearFrequency; markers m1 at 0.43333333GHz, m2 at 0.43423423GHz, m3 at 0.434GHz
  Smith: S(T_ANT,T_ANT), S(T_TX,T_TX), S(R_TX,R_TX), S(R_Rx,R_Rx), S(R_ANT,R_ANT) on 434meg : 434meg [Freq=all]
  R - S11, S22: dB(S(R_ANT,R_ANT)), dB(S(R_RX, R_RX)) vs Freq on LinearFrequency : LinearFrequency; markers m1 at 0.434GHz
  R - S12, S21: dB(S(R_ANT, R_RX)), dB(S(R_RX, R_ANT)) vs Freq on LinearFrequency : LinearFrequency; markers m1 at 0.434GHz
  R - Isolation: dB(S(R_RX, R_TX)), dB(S(R_TX, R_RX)), dB(S(R_ANT, R_TX)), dB(S(R_TX, R_ANT)) vs Freq on LinearFrequency : LinearFrequency; markers m1 at 0.434GHz
